simulator( 'ams )
design( "BVU025_Lary" "sim_Bias_cosim_A1" "config" )
openResults("/home/lary/simulation/BVU025/BVU025A/sim_Bias_cosim_A1/ams/config/psf")
selectResult('tran)
printf("=== FINAL VOLTAGES at t=1.0ms ===\n")
printf("aVdd = %g\n" value(v("aVdd") 1.0m))
printf("IBP_Res = %g\n" value(v("I_Bias.IBP_Res") 1.0m))
printf("VBP = %g\n" value(v("I_Bias.VBP") 1.0m))
printf("VBN = %g\n" value(v("I_Bias.VBN") 1.0m))
printf("VBNC = %g\n" value(v("I_Bias.VBNC") 1.0m))
printf("dIRefTMO = %g\n" value(v("dIRefTMO") 1.0m))
