simulator( 'ams )
design( "BVU025_Lary" "sim_Bias_cosim_A1" "config" )
openResults("/home/lary/simulation/BVU025/BVU025A/sim_Bias_cosim_A1/ams/config/psf")
selectResult('tran)
outp = outfile("/tmp/psf_tran_signals.txt")
fprintf(outp "v(net7) at 1.6ms = %g V\n" value(v("sim_Bias_cosim_A1.net7") 1.6m))
fprintf(outp "v(net4) at 0.8ms = %g V\n" value(v("sim_Bias_cosim_A1.net4") 0.8m))
fprintf(outp "v(xIRefTMIO2) at 1.6ms = %g V\n" value(v("sim_Bias_cosim_A1.xIRefTMIO2") 1.6m))
fprintf(outp "v(xIRefTMIO) at 1.6ms = %g V\n" value(v("sim_Bias_cosim_A1.xIRefTMIO") 1.6m))
close(outp)
exit()
