simulator( 'ams )
design( "BVU025_Lary" "sim_Bias_cosim_A1" "config" )
openResults("/home/lary/simulation/BVU025/BVU025A/sim_Bias_cosim_A1/ams/config/psf")
results()
selectResult('tran)
w = v("/V_IMeas/PLUS")
w_i = i("/V_IMeas/PLUS")
printf("w = %L\n" w)
printf("w_i = %L\n" w_i)
outp = outfile("/tmp/verify_tran_vimeas.txt")
fprintf(outp "w = %L, w_i = %L\n" w w_i)
close(outp)
exit()
