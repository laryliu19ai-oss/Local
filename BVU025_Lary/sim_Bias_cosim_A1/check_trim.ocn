simulator( 'ams )
design( "BVU025_Lary" "sim_Bias_cosim_A1" "config" )
openResults("/home/lary/simulation/BVU025/BVU025A/sim_Bias_cosim_A1/ams/config/psf")
selectResult('tran)
printf("aTrimRef_5 = %g\n" value(v("aTrimRef_5") 1.2m))
printf("aTrimRef_4 = %g\n" value(v("aTrimRef_4") 1.2m))
printf("Code_5 = %g\n" value(v("I_Bias.I0.Code_5") 1.2m))
printf("Code_i_5 = %g\n" value(v("I_Bias.I0.Code_i_5") 1.2m))
printf("Code_0 = %g\n" value(v("I_Bias.I0.Code_0") 1.2m))
printf("Code_i_0 = %g\n" value(v("I_Bias.I0.Code_i_0") 1.2m))
