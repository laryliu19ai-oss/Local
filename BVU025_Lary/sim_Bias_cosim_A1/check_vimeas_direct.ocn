simulator( 'ams )
design( "BVU025_Lary" "sim_Bias_cosim_A1" "config" )
openResults("/home/lary/simulation/BVU025/BVU025A/sim_Bias_cosim_A1/ams/config/psf")
selectResult('tran)
outp = outfile("/tmp/vimeas_current.txt")
fprintf(outp "I(V_IMeas:p) at 1.8ms = %g A\n" value(i("V_IMeas:p") 1.8m))
fprintf(outp "I(W1:1) at 1.8ms = %g A\n" value(i("W1:1") 1.8m))
fprintf(outp "I(I_Bias.MN8.d) at 1.8ms = %g A\n" value(i("sim_Bias_cosim_A1.I_Bias.MN8.d") 1.8m))
close(outp)
exit()
