simulator( 'ams )
design( "BVU025_Lary" "sim_Bias_cosim_A1" "config" )
openResults("/home/lary/simulation/BVU025/BVU025A/sim_Bias_cosim_A1/ams/config/psf")
selectResult('tran)
p = outfile("/tmp/ocean_voltages3.txt")
fprintf(p "Code_5 = %g\n" value(v("/I_Bias/I0/Code_5") 1.0m))
fprintf(p "net1_0 = %g\n" value(v("/I_Bias/I0/net1_0") 1.0m))
fprintf(p "Code_i_5 = %g\n" value(v("/I_Bias/I0/Code_i_5") 1.0m))
close(p)
exit()
