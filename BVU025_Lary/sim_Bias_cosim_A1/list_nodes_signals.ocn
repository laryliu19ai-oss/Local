simulator( 'ams )
design( "BVU025_Lary" "sim_Bias_cosim_A1" "config" )
openResults("/home/lary/simulation/BVU025/BVU025A/sim_Bias_cosim_A1/ams/config/psf")
selectResult('tran)
outp = outfile("/tmp/check_all_signals_viva.txt")
foreach( s nodes()
    fprintf(outp "node: %s\n" s)
)
foreach( s signals()
    fprintf(outp "signal: %s\n" s)
)
close(outp)
exit()
