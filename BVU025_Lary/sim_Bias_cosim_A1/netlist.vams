// AMS netlist generated by the AMS Unified netlister
// IC subversion:  IC6.1.8-64b.500.36
// Xcelium version: 24.09-s013
// Copyright(C) 2005-2009, Cadence Design Systems, Inc
// User: lary Pid: 2257
// Design library name: BVU025_Lary
// Design cell name: sim_Bias_cosim_A1
// Design view name: config
// Solver: Spectre

`include "disciplines.vams"
`include "userDisciplines.vams"
// HDL file - BVU025_Lary, vaSAR6b, veriloga.
// HDL file - BVU025_Lary, vaVDAC6b_FIXED, veriloga.

// --- Digital IHNL Modules ---
// File: digital/ihnl/cds0/netlist
// Library - BVU025_Lary, Cell - INVx2, View - schematic
// LAST TIME SAVED: Jul 31 16:03:52 2026
// NETLIST TIME: Aug 17 15:36:59 2026
`timescale 1ns / 1ns

`worklib BVU025_Lary
`view schematic

(* cds_ams_schematic *)
(* dfII_lib="BVU025_Lary", dfII_cell="INVx2", dfII_view="schematic", worklib_name="BVU025_Lary", view_name="schematic", last_save_time="Jul 31 16:03:52 2026" *)

module INVx2 (Z, VDD, VSS, A);

output  Z;

inout  VDD, VSS;

input  A;

endmodule

// File: digital/ihnl/cds1/netlist
// Library - umc18cdmos, Cell - RNHR3000_TG_CDMOS_G3, View - schematic
// NETLIST TIME: Aug 17 15:36:59 2026
`timescale 1ns / 1ns

`worklib umc18cdmos
`view schematic

(* cds_ams_schematic *)
(* dfII_lib="umc18cdmos", dfII_cell="RNHR3000_TG_CDMOS_G3", dfII_view="schematic", worklib_name="umc18cdmos", view_name="schematic" *)

module RNHR3000_TG_CDMOS_G3_pcell_0 (MINUS, PLUS, B);

parameter segW=2u;
parameter segL=10u;
parameter multi1=(1);
parameter mis_flag1=1;
parameter m=1;

inout  MINUS, PLUS;

input  B;

endmodule

// File: digital/ihnl/cds2/netlist
// Library - BVU025_Lary, Cell - NR2x2, View - schematic
// LAST TIME SAVED: Jul 31 18:58:48 2026
// NETLIST TIME: Aug 17 15:36:59 2026
`timescale 1ns / 1ns

`worklib BVU025_Lary
`view schematic

(* cds_ams_schematic *)
(* dfII_lib="BVU025_Lary", dfII_cell="NR2x2", dfII_view="schematic", worklib_name="BVU025_Lary", view_name="schematic", last_save_time="Jul 31 18:58:48 2026" *)

module NR2x2 (Z, VDD, VSS, A, B);

output  Z;

inout  VDD, VSS;

input  A, B;

endmodule

// File: digital/ihnl/cds3/netlist
// Library - BVU025_Lary, Cell - CMPTM_A1, View - schematic
// LAST TIME SAVED: Jul 31 19:06:38 2026
// NETLIST TIME: Aug 17 15:36:59 2026
`timescale 1ns / 1ns

`worklib BVU025_Lary
`view schematic

(* cds_ams_schematic *)
(* dfII_lib="BVU025_Lary", dfII_cell="CMPTM_A1", dfII_view="schematic", worklib_name="BVU025_Lary", view_name="schematic", last_save_time="Jul 31 19:06:38 2026" *)

module CMPTM_A1 (OUT, SUB, VDD, VSS, EnB, InN, InP, aVbp, aVbpc);

output  OUT;

inout  SUB, VDD, VSS;

input  EnB, InN, InP, aVbp, aVbpc;

INVx2 I1 ( .VDD(VDD), .VSS(VSS), .Z(OUT), .A(net4));

INVx2 I0 ( .VDD(VDD), .VSS(VSS), .Z(net4), .A(net5));

NR2x2 I2 ( .VDD(VDD), .VSS(VSS), .Z(net5), .A(EnB), .B(VO2));

endmodule

// File: digital/ihnl/cds4/netlist
// Library - umc18cdmos, Cell - RNHR4000_TG_CDMOS_G3, View - schematic
// NETLIST TIME: Aug 17 15:36:59 2026
`timescale 1ns / 1ns

`worklib umc18cdmos
`view schematic

(* cds_ams_schematic *)
(* dfII_lib="umc18cdmos", dfII_cell="RNHR4000_TG_CDMOS_G3", dfII_view="schematic", worklib_name="umc18cdmos", view_name="schematic" *)

module RNHR4000_TG_CDMOS_G3_pcell_1 (MINUS, PLUS, B);

parameter segW=2u;
parameter segL=10u;
parameter multi1=(1);
parameter mis_flag1=1;
parameter m=1;

inout  MINUS, PLUS;

input  B;

endmodule

// File: digital/ihnl/cds7/netlist
// Library - BVU025_Lary, Cell - IRef_R_A1, View - schematic
// LAST TIME SAVED: Aug  3 13:45:25 2026
// NETLIST TIME: Aug 17 15:36:59 2026
`timescale 1ns / 1ns

`worklib BVU025_Lary
`view schematic

(* cds_ams_schematic *)
(* dfII_lib="BVU025_Lary", dfII_cell="IRef_R_A1", dfII_view="schematic", worklib_name="BVU025_Lary", view_name="schematic", last_save_time="Aug  3 13:45:25 2026" *)

module IRef_R_A1 (aVdd, aVss, Code, aR_In);

inout  aVdd, aVss;

input  aR_In;

input [5:0]  Code;

// Buses in the design

wire  [0:5]  net1;

wire  [5:0]  Code_i;

wire  [67:1]  aN;

RNHR4000_TG_CDMOS_G3_pcell_1 #( .segL(16.17u), .segW(800n), .mis_flag1(1)
    , .multi1((1)), .m(1) ) (* integer passed_mfactor = "m"; *) R5_15 (
    .B(aVss), .MINUS(aN[30]), .PLUS(aN[31]));

RNHR4000_TG_CDMOS_G3_pcell_1 #( .segL(16.17u), .segW(800n), .mis_flag1(1)
    , .multi1((1)), .m(1) ) (* integer passed_mfactor = "m"; *) R5_14 (
    .B(aVss), .MINUS(aN[29]), .PLUS(aN[30]));

RNHR4000_TG_CDMOS_G3_pcell_1 #( .segL(16.17u), .segW(800n), .mis_flag1(1)
    , .multi1((1)), .m(1) ) (* integer passed_mfactor = "m"; *) R5_13 (
    .B(aVss), .MINUS(aN[28]), .PLUS(aN[29]));

RNHR4000_TG_CDMOS_G3_pcell_1 #( .segL(16.17u), .segW(800n), .mis_flag1(1)
    , .multi1((1)), .m(1) ) (* integer passed_mfactor = "m"; *) R5_12 (
    .B(aVss), .MINUS(aN[27]), .PLUS(aN[28]));

RNHR4000_TG_CDMOS_G3_pcell_1 #( .segL(16.17u), .segW(800n), .mis_flag1(1)
    , .multi1((1)), .m(1) ) (* integer passed_mfactor = "m"; *) R5_11 (
    .B(aVss), .MINUS(aN[26]), .PLUS(aN[27]));

RNHR4000_TG_CDMOS_G3_pcell_1 #( .segL(16.17u), .segW(800n), .mis_flag1(1)
    , .multi1((1)), .m(1) ) (* integer passed_mfactor = "m"; *) R5_10 (
    .B(aVss), .MINUS(aN[25]), .PLUS(aN[26]));

RNHR4000_TG_CDMOS_G3_pcell_1 #( .segL(16.17u), .segW(800n), .mis_flag1(1)
    , .multi1((1)), .m(1) ) (* integer passed_mfactor = "m"; *) R5_9 (
    .B(aVss), .MINUS(aN[24]), .PLUS(aN[25]));

RNHR4000_TG_CDMOS_G3_pcell_1 #( .segL(16.17u), .segW(800n), .mis_flag1(1)
    , .multi1((1)), .m(1) ) (* integer passed_mfactor = "m"; *) R5_8 (
    .B(aVss), .MINUS(aN[23]), .PLUS(aN[24]));

RNHR4000_TG_CDMOS_G3_pcell_1 #( .segL(16.17u), .segW(800n), .mis_flag1(1)
    , .multi1((1)), .m(1) ) (* integer passed_mfactor = "m"; *) R5_7 (
    .B(aVss), .MINUS(aN[22]), .PLUS(aN[23]));

RNHR4000_TG_CDMOS_G3_pcell_1 #( .segL(16.17u), .segW(800n), .mis_flag1(1)
    , .multi1((1)), .m(1) ) (* integer passed_mfactor = "m"; *) R5_6 (
    .B(aVss), .MINUS(aN[21]), .PLUS(aN[22]));

RNHR4000_TG_CDMOS_G3_pcell_1 #( .segL(16.17u), .segW(800n), .mis_flag1(1)
    , .multi1((1)), .m(1) ) (* integer passed_mfactor = "m"; *) R5_5 (
    .B(aVss), .MINUS(aN[20]), .PLUS(aN[21]));

RNHR4000_TG_CDMOS_G3_pcell_1 #( .segL(16.17u), .segW(800n), .mis_flag1(1)
    , .multi1((1)), .m(1) ) (* integer passed_mfactor = "m"; *) R5_4 (
    .B(aVss), .MINUS(aN[19]), .PLUS(aN[20]));

RNHR4000_TG_CDMOS_G3_pcell_1 #( .segL(16.17u), .segW(800n), .mis_flag1(1)
    , .multi1((1)), .m(1) ) (* integer passed_mfactor = "m"; *) R5_3 (
    .B(aVss), .MINUS(aN[18]), .PLUS(aN[19]));

RNHR4000_TG_CDMOS_G3_pcell_1 #( .segL(16.17u), .segW(800n), .mis_flag1(1)
    , .multi1((1)), .m(1) ) (* integer passed_mfactor = "m"; *) R5_2 (
    .B(aVss), .MINUS(aN[17]), .PLUS(aN[18]));

RNHR4000_TG_CDMOS_G3_pcell_1 #( .segL(16.17u), .segW(800n), .mis_flag1(1)
    , .multi1((1)), .m(1) ) (* integer passed_mfactor = "m"; *) R5_1 (
    .B(aVss), .MINUS(aN[16]), .PLUS(aN[17]));

RNHR4000_TG_CDMOS_G3_pcell_1 #( .segL(16.17u), .segW(800n), .mis_flag1(1)
    , .multi1((1)), .m(1) ) (* integer passed_mfactor = "m"; *) R5_0 (
    .B(aVss), .MINUS(aN[15]), .PLUS(aN[16]));

RNHR4000_TG_CDMOS_G3_pcell_1 #( .segL(16.17u), .segW(800n), .mis_flag1(1)
    , .multi1((1)), .m(1) ) (* integer passed_mfactor = "m"; *) R4_7 (
    .B(aVss), .MINUS(aN[14]), .PLUS(aN[15]));

RNHR4000_TG_CDMOS_G3_pcell_1 #( .segL(16.17u), .segW(800n), .mis_flag1(1)
    , .multi1((1)), .m(1) ) (* integer passed_mfactor = "m"; *) R4_6 (
    .B(aVss), .MINUS(aN[13]), .PLUS(aN[14]));

RNHR4000_TG_CDMOS_G3_pcell_1 #( .segL(16.17u), .segW(800n), .mis_flag1(1)
    , .multi1((1)), .m(1) ) (* integer passed_mfactor = "m"; *) R4_5 (
    .B(aVss), .MINUS(aN[12]), .PLUS(aN[13]));

RNHR4000_TG_CDMOS_G3_pcell_1 #( .segL(16.17u), .segW(800n), .mis_flag1(1)
    , .multi1((1)), .m(1) ) (* integer passed_mfactor = "m"; *) R4_4 (
    .B(aVss), .MINUS(aN[11]), .PLUS(aN[12]));

RNHR4000_TG_CDMOS_G3_pcell_1 #( .segL(16.17u), .segW(800n), .mis_flag1(1)
    , .multi1((1)), .m(1) ) (* integer passed_mfactor = "m"; *) R4_3 (
    .B(aVss), .MINUS(aN[10]), .PLUS(aN[11]));

RNHR4000_TG_CDMOS_G3_pcell_1 #( .segL(16.17u), .segW(800n), .mis_flag1(1)
    , .multi1((1)), .m(1) ) (* integer passed_mfactor = "m"; *) R4_2 (
    .B(aVss), .MINUS(aN[9]), .PLUS(aN[10]));

RNHR4000_TG_CDMOS_G3_pcell_1 #( .segL(16.17u), .segW(800n), .mis_flag1(1)
    , .multi1((1)), .m(1) ) (* integer passed_mfactor = "m"; *) R4_1 (
    .B(aVss), .MINUS(aN[8]), .PLUS(aN[9]));

RNHR4000_TG_CDMOS_G3_pcell_1 #( .segL(16.17u), .segW(800n), .mis_flag1(1)
    , .multi1((1)), .m(1) ) (* integer passed_mfactor = "m"; *) R4_0 (
    .B(aVss), .MINUS(aN[7]), .PLUS(aN[8]));

RNHR4000_TG_CDMOS_G3_pcell_1 #( .segL(16.17u), .segW(800n), .mis_flag1(1)
    , .multi1((1)), .m(1) ) (* integer passed_mfactor = "m"; *) R1 (
    .B(aVss), .MINUS(aVss), .PLUS(aN[1]));

RNHR4000_TG_CDMOS_G3_pcell_1 #( .segL(16.17u), .segW(800n), .mis_flag1(1)
    , .multi1((1)), .m(1) ) (* integer passed_mfactor = "m"; *) R3_3 (
    .B(aVss), .MINUS(aN[6]), .PLUS(aN[7]));

RNHR4000_TG_CDMOS_G3_pcell_1 #( .segL(16.17u), .segW(800n), .mis_flag1(1)
    , .multi1((1)), .m(1) ) (* integer passed_mfactor = "m"; *) R3_2 (
    .B(aVss), .MINUS(aN[5]), .PLUS(aN[6]));

RNHR4000_TG_CDMOS_G3_pcell_1 #( .segL(16.17u), .segW(800n), .mis_flag1(1)
    , .multi1((1)), .m(1) ) (* integer passed_mfactor = "m"; *) R3_1 (
    .B(aVss), .MINUS(aN[4]), .PLUS(aN[5]));

RNHR4000_TG_CDMOS_G3_pcell_1 #( .segL(16.17u), .segW(800n), .mis_flag1(1)
    , .multi1((1)), .m(1) ) (* integer passed_mfactor = "m"; *) R3_0 (
    .B(aVss), .MINUS(aN[3]), .PLUS(aN[4]));

RNHR4000_TG_CDMOS_G3_pcell_1 #( .segL(16.17u), .segW(800n), .mis_flag1(1)
    , .multi1((1)), .m(1) ) (* integer passed_mfactor = "m"; *) R2_1 (
    .B(aVss), .MINUS(aN[2]), .PLUS(aN[3]));

RNHR4000_TG_CDMOS_G3_pcell_1 #( .segL(16.17u), .segW(800n), .mis_flag1(1)
    , .multi1((1)), .m(1) ) (* integer passed_mfactor = "m"; *) R2_0 (
    .B(aVss), .MINUS(aN[1]), .PLUS(aN[2]));

RNHR4000_TG_CDMOS_G3_pcell_1 #( .segL(16.17u), .segW(800n), .mis_flag1(1)
    , .multi1((1)), .m(1) ) (* integer passed_mfactor = "m"; *) R6_31 (
    .B(aVss), .MINUS(aN[62]), .PLUS(aN[63]));

RNHR4000_TG_CDMOS_G3_pcell_1 #( .segL(16.17u), .segW(800n), .mis_flag1(1)
    , .multi1((1)), .m(1) ) (* integer passed_mfactor = "m"; *) R6_30 (
    .B(aVss), .MINUS(aN[61]), .PLUS(aN[62]));

RNHR4000_TG_CDMOS_G3_pcell_1 #( .segL(16.17u), .segW(800n), .mis_flag1(1)
    , .multi1((1)), .m(1) ) (* integer passed_mfactor = "m"; *) R6_29 (
    .B(aVss), .MINUS(aN[60]), .PLUS(aN[61]));

RNHR4000_TG_CDMOS_G3_pcell_1 #( .segL(16.17u), .segW(800n), .mis_flag1(1)
    , .multi1((1)), .m(1) ) (* integer passed_mfactor = "m"; *) R6_28 (
    .B(aVss), .MINUS(aN[59]), .PLUS(aN[60]));

RNHR4000_TG_CDMOS_G3_pcell_1 #( .segL(16.17u), .segW(800n), .mis_flag1(1)
    , .multi1((1)), .m(1) ) (* integer passed_mfactor = "m"; *) R6_27 (
    .B(aVss), .MINUS(aN[58]), .PLUS(aN[59]));

RNHR4000_TG_CDMOS_G3_pcell_1 #( .segL(16.17u), .segW(800n), .mis_flag1(1)
    , .multi1((1)), .m(1) ) (* integer passed_mfactor = "m"; *) R6_26 (
    .B(aVss), .MINUS(aN[57]), .PLUS(aN[58]));

RNHR4000_TG_CDMOS_G3_pcell_1 #( .segL(16.17u), .segW(800n), .mis_flag1(1)
    , .multi1((1)), .m(1) ) (* integer passed_mfactor = "m"; *) R6_25 (
    .B(aVss), .MINUS(aN[56]), .PLUS(aN[57]));

RNHR4000_TG_CDMOS_G3_pcell_1 #( .segL(16.17u), .segW(800n), .mis_flag1(1)
    , .multi1((1)), .m(1) ) (* integer passed_mfactor = "m"; *) R6_24 (
    .B(aVss), .MINUS(aN[55]), .PLUS(aN[56]));

RNHR4000_TG_CDMOS_G3_pcell_1 #( .segL(16.17u), .segW(800n), .mis_flag1(1)
    , .multi1((1)), .m(1) ) (* integer passed_mfactor = "m"; *) R6_23 (
    .B(aVss), .MINUS(aN[54]), .PLUS(aN[55]));

RNHR4000_TG_CDMOS_G3_pcell_1 #( .segL(16.17u), .segW(800n), .mis_flag1(1)
    , .multi1((1)), .m(1) ) (* integer passed_mfactor = "m"; *) R6_22 (
    .B(aVss), .MINUS(aN[53]), .PLUS(aN[54]));

RNHR4000_TG_CDMOS_G3_pcell_1 #( .segL(16.17u), .segW(800n), .mis_flag1(1)
    , .multi1((1)), .m(1) ) (* integer passed_mfactor = "m"; *) R6_21 (
    .B(aVss), .MINUS(aN[52]), .PLUS(aN[53]));

RNHR4000_TG_CDMOS_G3_pcell_1 #( .segL(16.17u), .segW(800n), .mis_flag1(1)
    , .multi1((1)), .m(1) ) (* integer passed_mfactor = "m"; *) R6_20 (
    .B(aVss), .MINUS(aN[51]), .PLUS(aN[52]));

RNHR4000_TG_CDMOS_G3_pcell_1 #( .segL(16.17u), .segW(800n), .mis_flag1(1)
    , .multi1((1)), .m(1) ) (* integer passed_mfactor = "m"; *) R6_19 (
    .B(aVss), .MINUS(aN[50]), .PLUS(aN[51]));

RNHR4000_TG_CDMOS_G3_pcell_1 #( .segL(16.17u), .segW(800n), .mis_flag1(1)
    , .multi1((1)), .m(1) ) (* integer passed_mfactor = "m"; *) R6_18 (
    .B(aVss), .MINUS(aN[49]), .PLUS(aN[50]));

RNHR4000_TG_CDMOS_G3_pcell_1 #( .segL(16.17u), .segW(800n), .mis_flag1(1)
    , .multi1((1)), .m(1) ) (* integer passed_mfactor = "m"; *) R6_17 (
    .B(aVss), .MINUS(aN[48]), .PLUS(aN[49]));

RNHR4000_TG_CDMOS_G3_pcell_1 #( .segL(16.17u), .segW(800n), .mis_flag1(1)
    , .multi1((1)), .m(1) ) (* integer passed_mfactor = "m"; *) R6_16 (
    .B(aVss), .MINUS(aN[47]), .PLUS(aN[48]));

RNHR4000_TG_CDMOS_G3_pcell_1 #( .segL(16.17u), .segW(800n), .mis_flag1(1)
    , .multi1((1)), .m(1) ) (* integer passed_mfactor = "m"; *) R6_15 (
    .B(aVss), .MINUS(aN[46]), .PLUS(aN[47]));

RNHR4000_TG_CDMOS_G3_pcell_1 #( .segL(16.17u), .segW(800n), .mis_flag1(1)
    , .multi1((1)), .m(1) ) (* integer passed_mfactor = "m"; *) R6_14 (
    .B(aVss), .MINUS(aN[45]), .PLUS(aN[46]));

RNHR4000_TG_CDMOS_G3_pcell_1 #( .segL(16.17u), .segW(800n), .mis_flag1(1)
    , .multi1((1)), .m(1) ) (* integer passed_mfactor = "m"; *) R6_13 (
    .B(aVss), .MINUS(aN[44]), .PLUS(aN[45]));

RNHR4000_TG_CDMOS_G3_pcell_1 #( .segL(16.17u), .segW(800n), .mis_flag1(1)
    , .multi1((1)), .m(1) ) (* integer passed_mfactor = "m"; *) R6_12 (
    .B(aVss), .MINUS(aN[43]), .PLUS(aN[44]));

RNHR4000_TG_CDMOS_G3_pcell_1 #( .segL(16.17u), .segW(800n), .mis_flag1(1)
    , .multi1((1)), .m(1) ) (* integer passed_mfactor = "m"; *) R6_11 (
    .B(aVss), .MINUS(aN[42]), .PLUS(aN[43]));

RNHR4000_TG_CDMOS_G3_pcell_1 #( .segL(16.17u), .segW(800n), .mis_flag1(1)
    , .multi1((1)), .m(1) ) (* integer passed_mfactor = "m"; *) R6_10 (
    .B(aVss), .MINUS(aN[41]), .PLUS(aN[42]));

RNHR4000_TG_CDMOS_G3_pcell_1 #( .segL(16.17u), .segW(800n), .mis_flag1(1)
    , .multi1((1)), .m(1) ) (* integer passed_mfactor = "m"; *) R6_9 (
    .B(aVss), .MINUS(aN[40]), .PLUS(aN[41]));

RNHR4000_TG_CDMOS_G3_pcell_1 #( .segL(16.17u), .segW(800n), .mis_flag1(1)
    , .multi1((1)), .m(1) ) (* integer passed_mfactor = "m"; *) R6_8 (
    .B(aVss), .MINUS(aN[39]), .PLUS(aN[40]));

RNHR4000_TG_CDMOS_G3_pcell_1 #( .segL(16.17u), .segW(800n), .mis_flag1(1)
    , .multi1((1)), .m(1) ) (* integer passed_mfactor = "m"; *) R6_7 (
    .B(aVss), .MINUS(aN[38]), .PLUS(aN[39]));

RNHR4000_TG_CDMOS_G3_pcell_1 #( .segL(16.17u), .segW(800n), .mis_flag1(1)
    , .multi1((1)), .m(1) ) (* integer passed_mfactor = "m"; *) R6_6 (
    .B(aVss), .MINUS(aN[37]), .PLUS(aN[38]));

RNHR4000_TG_CDMOS_G3_pcell_1 #( .segL(16.17u), .segW(800n), .mis_flag1(1)
    , .multi1((1)), .m(1) ) (* integer passed_mfactor = "m"; *) R6_5 (
    .B(aVss), .MINUS(aN[36]), .PLUS(aN[37]));

RNHR4000_TG_CDMOS_G3_pcell_1 #( .segL(16.17u), .segW(800n), .mis_flag1(1)
    , .multi1((1)), .m(1) ) (* integer passed_mfactor = "m"; *) R6_4 (
    .B(aVss), .MINUS(aN[35]), .PLUS(aN[36]));

RNHR4000_TG_CDMOS_G3_pcell_1 #( .segL(16.17u), .segW(800n), .mis_flag1(1)
    , .multi1((1)), .m(1) ) (* integer passed_mfactor = "m"; *) R6_3 (
    .B(aVss), .MINUS(aN[34]), .PLUS(aN[35]));

RNHR4000_TG_CDMOS_G3_pcell_1 #( .segL(16.17u), .segW(800n), .mis_flag1(1)
    , .multi1((1)), .m(1) ) (* integer passed_mfactor = "m"; *) R6_2 (
    .B(aVss), .MINUS(aN[33]), .PLUS(aN[34]));

RNHR4000_TG_CDMOS_G3_pcell_1 #( .segL(16.17u), .segW(800n), .mis_flag1(1)
    , .multi1((1)), .m(1) ) (* integer passed_mfactor = "m"; *) R6_1 (
    .B(aVss), .MINUS(aN[32]), .PLUS(aN[33]));

RNHR4000_TG_CDMOS_G3_pcell_1 #( .segL(16.17u), .segW(800n), .mis_flag1(1)
    , .multi1((1)), .m(1) ) (* integer passed_mfactor = "m"; *) R6_0 (
    .B(aVss), .MINUS(aN[31]), .PLUS(aN[32]));

RNHR4000_TG_CDMOS_G3_pcell_1 #( .segL(16.17u), .segW(800n), .mis_flag1(1)
    , .multi1((1)), .m(1) ) (* integer passed_mfactor = "m"; *) R7_3 (
    .B(aVss), .MINUS(aN[66]), .PLUS(aN[67]));

RNHR4000_TG_CDMOS_G3_pcell_1 #( .segL(16.17u), .segW(800n), .mis_flag1(1)
    , .multi1((1)), .m(1) ) (* integer passed_mfactor = "m"; *) R7_2 (
    .B(aVss), .MINUS(aN[65]), .PLUS(aN[66]));

RNHR4000_TG_CDMOS_G3_pcell_1 #( .segL(16.17u), .segW(800n), .mis_flag1(1)
    , .multi1((1)), .m(1) ) (* integer passed_mfactor = "m"; *) R7_1 (
    .B(aVss), .MINUS(aN[64]), .PLUS(aN[65]));

RNHR4000_TG_CDMOS_G3_pcell_1 #( .segL(16.17u), .segW(800n), .mis_flag1(1)
    , .multi1((1)), .m(1) ) (* integer passed_mfactor = "m"; *) R7_0 (
    .B(aVss), .MINUS(aN[63]), .PLUS(aN[64]));

RNHR4000_TG_CDMOS_G3_pcell_1 #( .segL(16.17u), .segW(800n), .mis_flag1(1)
    , .multi1((1)), .m(1) ) (* integer passed_mfactor = "m"; *) RT_1 (
    .B(aVss), .MINUS(aN[67]), .PLUS(aR_In));

INVx2 I0_5 ( .VDD(aVdd), .VSS(aVss), .Z(net1[0]), .A(Code[5]));

INVx2 I0_4 ( .VDD(aVdd), .VSS(aVss), .Z(net1[1]), .A(Code[4]));

INVx2 I0_3 ( .VDD(aVdd), .VSS(aVss), .Z(net1[2]), .A(Code[3]));

INVx2 I0_2 ( .VDD(aVdd), .VSS(aVss), .Z(net1[3]), .A(Code[2]));

INVx2 I0_1 ( .VDD(aVdd), .VSS(aVss), .Z(net1[4]), .A(Code[1]));

INVx2 I0_0 ( .VDD(aVdd), .VSS(aVss), .Z(net1[5]), .A(Code[0]));

INVx2 I1_5 ( .VDD(aVdd), .VSS(aVss), .Z(Code_i[5]), .A(net1[0]));

INVx2 I1_4 ( .VDD(aVdd), .VSS(aVss), .Z(Code_i[4]), .A(net1[1]));

INVx2 I1_3 ( .VDD(aVdd), .VSS(aVss), .Z(Code_i[3]), .A(net1[2]));

INVx2 I1_2 ( .VDD(aVdd), .VSS(aVss), .Z(Code_i[2]), .A(net1[3]));

INVx2 I1_1 ( .VDD(aVdd), .VSS(aVss), .Z(Code_i[1]), .A(net1[4]));

INVx2 I1_0 ( .VDD(aVdd), .VSS(aVss), .Z(Code_i[0]), .A(net1[5]));

endmodule

// File: digital/ihnl/cds8/netlist
// Library - BVU025_Lary, Cell - Bias_A1, View - schematic
// LAST TIME SAVED: Aug  5 15:51:44 2026
// NETLIST TIME: Aug 17 15:36:59 2026
`timescale 1ns / 1ns

`worklib BVU025_Lary
`view schematic

(* cds_ams_schematic *)
(* dfII_lib="BVU025_Lary", dfII_cell="Bias_A1", dfII_view="schematic", worklib_name="BVU025_Lary", view_name="schematic", last_save_time="Aug  5 15:51:44 2026" *)

module Bias_A1 (IRefTMO, ibp_250n, SUB, VBNC, VBNC1, aVdd, aVss, En,
    TMIRefMeas, TMIRefOn, rgTrim_IRef, xIRefTMIO);

output  IRefTMO;

inout  SUB, VBNC, VBNC1, aVdd, aVss;

input  En, TMIRefMeas, TMIRefOn, xIRefTMIO;

output [0:0]  ibp_250n;

input [5:0]  rgTrim_IRef;

// Buses in the design

wire  [15:1]  netR13;

wire  [7:1]  netR10;

INVx2 I5 ( .VDD(aVdd), .VSS(aVss), .Z(EnA), .A(EnB));

INVx2 I4 ( .VDD(aVdd), .VSS(aVss), .Z(EnB), .A(En));

INVx2 I3 ( .VDD(aVdd), .VSS(aVss), .Z(TMIRefOnA), .A(TMIRefOnB));

INVx2 I2 ( .VDD(aVdd), .VSS(aVss), .Z(TMIRefOnB), .A(TMIRefOn));

INVx2 I1 ( .VDD(aVdd), .VSS(aVss), .Z(TMIRefMeasB), .A(TMIRefMeas));

RNHR3000_TG_CDMOS_G3_pcell_0 #( .segL(15.6u), .segW(440n), .mis_flag1(1)
    , .multi1((1)), .m(1) ) (* integer passed_mfactor = "m"; *) R0 (
    .B(aVdd), .MINUS(net1), .PLUS(VBP));

CMPTM_A1 I6 ( .SUB(SUB), .VSS(aVss), .VDD(aVdd), .OUT(IRefTMO),
    .EnB(TMIRefOnB), .InP(IBP_Res), .InN(xIRefTMIOi), .aVbp(VBP),
    .aVbpc(VBPC));

RNHR4000_TG_CDMOS_G3_pcell_1 #( .segL(9.2u), .segW(800n), .mis_flag1(1), .multi1((1))
    , .m(1) ) (* integer passed_mfactor = "m"; *) R13_15 ( .B(aVss),
    .MINUS(netR13[15]), .PLUS(IBP_Res));

RNHR4000_TG_CDMOS_G3_pcell_1 #( .segL(9.2u), .segW(800n), .mis_flag1(1), .multi1((1))
    , .m(1) ) (* integer passed_mfactor = "m"; *) R13_14 ( .B(aVss),
    .MINUS(netR13[14]), .PLUS(netR13[15]));

RNHR4000_TG_CDMOS_G3_pcell_1 #( .segL(9.2u), .segW(800n), .mis_flag1(1), .multi1((1))
    , .m(1) ) (* integer passed_mfactor = "m"; *) R13_13 ( .B(aVss),
    .MINUS(netR13[13]), .PLUS(netR13[14]));

RNHR4000_TG_CDMOS_G3_pcell_1 #( .segL(9.2u), .segW(800n), .mis_flag1(1), .multi1((1))
    , .m(1) ) (* integer passed_mfactor = "m"; *) R13_12 ( .B(aVss),
    .MINUS(netR13[12]), .PLUS(netR13[13]));

RNHR4000_TG_CDMOS_G3_pcell_1 #( .segL(9.2u), .segW(800n), .mis_flag1(1), .multi1((1))
    , .m(1) ) (* integer passed_mfactor = "m"; *) R13_11 ( .B(aVss),
    .MINUS(netR13[11]), .PLUS(netR13[12]));

RNHR4000_TG_CDMOS_G3_pcell_1 #( .segL(9.2u), .segW(800n), .mis_flag1(1), .multi1((1))
    , .m(1) ) (* integer passed_mfactor = "m"; *) R13_10 ( .B(aVss),
    .MINUS(netR13[10]), .PLUS(netR13[11]));

RNHR4000_TG_CDMOS_G3_pcell_1 #( .segL(9.2u), .segW(800n), .mis_flag1(1), .multi1((1))
    , .m(1) ) (* integer passed_mfactor = "m"; *) R13_9 ( .B(aVss),
    .MINUS(netR13[9]), .PLUS(netR13[10]));

RNHR4000_TG_CDMOS_G3_pcell_1 #( .segL(9.2u), .segW(800n), .mis_flag1(1), .multi1((1))
    , .m(1) ) (* integer passed_mfactor = "m"; *) R13_8 ( .B(aVss),
    .MINUS(netR13[8]), .PLUS(netR13[9]));

RNHR4000_TG_CDMOS_G3_pcell_1 #( .segL(9.2u), .segW(800n), .mis_flag1(1), .multi1((1))
    , .m(1) ) (* integer passed_mfactor = "m"; *) R13_7 ( .B(aVss),
    .MINUS(netR13[7]), .PLUS(netR13[8]));

RNHR4000_TG_CDMOS_G3_pcell_1 #( .segL(9.2u), .segW(800n), .mis_flag1(1), .multi1((1))
    , .m(1) ) (* integer passed_mfactor = "m"; *) R13_6 ( .B(aVss),
    .MINUS(netR13[6]), .PLUS(netR13[7]));

RNHR4000_TG_CDMOS_G3_pcell_1 #( .segL(9.2u), .segW(800n), .mis_flag1(1), .multi1((1))
    , .m(1) ) (* integer passed_mfactor = "m"; *) R13_5 ( .B(aVss),
    .MINUS(netR13[5]), .PLUS(netR13[6]));

RNHR4000_TG_CDMOS_G3_pcell_1 #( .segL(9.2u), .segW(800n), .mis_flag1(1), .multi1((1))
    , .m(1) ) (* integer passed_mfactor = "m"; *) R13_4 ( .B(aVss),
    .MINUS(netR13[4]), .PLUS(netR13[5]));

RNHR4000_TG_CDMOS_G3_pcell_1 #( .segL(9.2u), .segW(800n), .mis_flag1(1), .multi1((1))
    , .m(1) ) (* integer passed_mfactor = "m"; *) R13_3 ( .B(aVss),
    .MINUS(netR13[3]), .PLUS(netR13[4]));

RNHR4000_TG_CDMOS_G3_pcell_1 #( .segL(9.2u), .segW(800n), .mis_flag1(1), .multi1((1))
    , .m(1) ) (* integer passed_mfactor = "m"; *) R13_2 ( .B(aVss),
    .MINUS(netR13[2]), .PLUS(netR13[3]));

RNHR4000_TG_CDMOS_G3_pcell_1 #( .segL(9.2u), .segW(800n), .mis_flag1(1), .multi1((1))
    , .m(1) ) (* integer passed_mfactor = "m"; *) R13_1 ( .B(aVss),
    .MINUS(netR13[1]), .PLUS(netR13[2]));

RNHR4000_TG_CDMOS_G3_pcell_1 #( .segL(9.2u), .segW(800n), .mis_flag1(1), .multi1((1))
    , .m(1) ) (* integer passed_mfactor = "m"; *) R13_0 ( .B(aVss),
    .MINUS(aVss), .PLUS(netR13[1]));

RNHR4000_TG_CDMOS_G3_pcell_1 #( .segL(2.4u), .segW(800n), .mis_flag1(1), .multi1((1))
    , .m(1) ) (* integer passed_mfactor = "m"; *) R2 ( .B(aVss),
    .MINUS(TMIO_ESD), .PLUS(xIRefTMIO));

RNHR4000_TG_CDMOS_G3_pcell_1 #( .segL(9.2u), .segW(800n), .mis_flag1(1), .multi1((1))
    , .m(1) ) (* integer passed_mfactor = "m"; *) R10_7 ( .B(aVss),
    .MINUS(netR10[7]), .PLUS(xIRefTMIOi));

RNHR4000_TG_CDMOS_G3_pcell_1 #( .segL(9.2u), .segW(800n), .mis_flag1(1), .multi1((1))
    , .m(1) ) (* integer passed_mfactor = "m"; *) R10_6 ( .B(aVss),
    .MINUS(netR10[6]), .PLUS(netR10[7]));

RNHR4000_TG_CDMOS_G3_pcell_1 #( .segL(9.2u), .segW(800n), .mis_flag1(1), .multi1((1))
    , .m(1) ) (* integer passed_mfactor = "m"; *) R10_5 ( .B(aVss),
    .MINUS(netR10[5]), .PLUS(netR10[6]));

RNHR4000_TG_CDMOS_G3_pcell_1 #( .segL(9.2u), .segW(800n), .mis_flag1(1), .multi1((1))
    , .m(1) ) (* integer passed_mfactor = "m"; *) R10_4 ( .B(aVss),
    .MINUS(netR10[4]), .PLUS(netR10[5]));

RNHR4000_TG_CDMOS_G3_pcell_1 #( .segL(9.2u), .segW(800n), .mis_flag1(1), .multi1((1))
    , .m(1) ) (* integer passed_mfactor = "m"; *) R10_3 ( .B(aVss),
    .MINUS(netR10[3]), .PLUS(netR10[4]));

RNHR4000_TG_CDMOS_G3_pcell_1 #( .segL(9.2u), .segW(800n), .mis_flag1(1), .multi1((1))
    , .m(1) ) (* integer passed_mfactor = "m"; *) R10_2 ( .B(aVss),
    .MINUS(netR10[2]), .PLUS(netR10[3]));

RNHR4000_TG_CDMOS_G3_pcell_1 #( .segL(9.2u), .segW(800n), .mis_flag1(1), .multi1((1))
    , .m(1) ) (* integer passed_mfactor = "m"; *) R10_1 ( .B(aVss),
    .MINUS(netR10[1]), .PLUS(netR10[2]));

RNHR4000_TG_CDMOS_G3_pcell_1 #( .segL(9.2u), .segW(800n), .mis_flag1(1), .multi1((1))
    , .m(1) ) (* integer passed_mfactor = "m"; *) R10_0 ( .B(aVss),
    .MINUS(aVss), .PLUS(netR10[1]));

IRef_R_A1 I0 ( .aVss(aVss), .aVdd(aVdd), .aR_In(VBN),
    .Code(rgTrim_IRef[5:0]));

endmodule

// File: digital/ihnl/cds9/netlist
// Library - BVU025_Lary, Cell - AN2x1, View - schematic
// LAST TIME SAVED: Jul 31 19:49:03 2026
// NETLIST TIME: Aug 17 15:36:59 2026
`timescale 1ns / 1ns

`worklib BVU025_Lary
`view schematic

(* cds_ams_schematic *)
(* dfII_lib="BVU025_Lary", dfII_cell="AN2x1", dfII_view="schematic", worklib_name="BVU025_Lary", view_name="schematic", last_save_time="Jul 31 19:49:03 2026" *)

module AN2x1 (Z, VDD, VSS, A, B);

output  Z;

inout  VDD, VSS;

input  A, B;

endmodule

// File: digital/ihnl/cds10/netlist
// Library - BVU025_Lary, Cell - sim_Bias_cosim_A1, View -
//schematic_SAR
// LAST TIME SAVED: Aug 17 15:36:43 2026
// NETLIST TIME: Aug 17 15:36:59 2026
`timescale 1ns / 1ns

`worklib BVU025_Lary
`view schematic_SAR

(* cds_ams_schematic *)
(* dfII_lib="BVU025_Lary", dfII_cell="sim_Bias_cosim_A1", dfII_view="schematic_SAR", worklib_name="BVU025_Lary", view_name="schematic_SAR", last_save_time="Aug 17 15:36:43 2026" *)

module sim_Bias_cosim_A1 ();

electrical aVdd, aVss, SUB, net3, xIRefTMIO, VBNC, DVDD_Trm, IREF_TrmCode;
electrical TMIRefOn, TMIRefMeas, TMIRefOni, TMIRefMeasi, CLK, POR, dDone, dIRefTMO, net5, net6;
wire  [5:0]  NvTrmIref;

Bias_A1 I_Bias ( .SUB(SUB), .aVss(aVss), .aVdd(aVdd),
    .IRefTMO(dIRefTMO), .ibp_250n(net3), .En(aVdd),
    .rgTrim_IRef(NvTrmIref[5:0]), .TMIRefOn(TMIRefOni),
    .xIRefTMIO(xIRefTMIO), .TMIRefMeas(TMIRefMeasi), .VBNC(VBNC),
    .VBNC1(VBNC));

vaVDAC6b_FIXED #( .transmission_delay_max(1e-09), .transmission_delay(1e-11)
    , .threshold_low(0.25), .slew_rate_positive(1e+06), .slew_rate_negative(-1e+06)
    , .threshold_high(0.75), .mode_decimal_display(1) )  I_Code (
    .VSS(cds_globals.\gnd! ), .VDD(DVDD_Trm), .VO(IREF_TrmCode),
    .DI(NvTrmIref));

vaSAR6b #( .threshold_low(0.25), .threshold_high(0.75), .comp_invert(0), .fall_time(1e-11)
    , .rise_time(1e-11), .delay(1e-11) )  I_SAR6b (
    .VSS(cds_globals.\gnd! ), .VDD(DVDD_Trm), .CODE(NvTrmIref),
    .DONE(dDone), .EN(POR), .CLK(CLK), .CMP(dIRefTMO));

AN2x1 I_CLKCtl ( .VSS(cds_globals.\gnd! ), .VDD(DVDD_Trm), .Z(CLK),
    .A(net5), .B(net6));

endmodule
