simulator( 'ams )
design( "BVU025_Lary" "sim_Bias_cosim_A1" "config" )
openResults("/home/lary/simulation/BVU025/BVU025A/sim_Bias_cosim_A1/ams/config/psf")
selectResult('tran)
outp = outfile("/tmp/all_psf_outputs.txt")
foreach( o outputs()
    fprintf(outp "%s\n" o)
)
close(outp)
exit()
