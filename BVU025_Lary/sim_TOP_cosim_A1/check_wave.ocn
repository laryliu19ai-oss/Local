simulator('ams)
design("BVU025_Lary" "sim_TOP_cosim_A1" "config")
openResults("/home/lary/simulation/BVU025/BVU025A/sim_TOP_cosim_A1/ams/config/psf")
selectResult('tran)

let((v_avdd v_tmon v_tmmeas v_gpio8)
    v_avdd = value(v("sim_TOP_cosim_A1.aVdd") 1e-3)
    v_tmon = value(v("sim_TOP_cosim_A1.TMIRefOn") 1e-3)
    v_tmmeas = value(v("sim_TOP_cosim_A1.TMIRefMeas") 1.6e-3)
    v_gpio8 = value(v("sim_TOP_cosim_A1.GPIO8") 1.6e-3)

    printf("=== VERIFICATION RESULTS ===\n")
    printf("aVdd at 1ms = %g V\n" v_avdd)
    printf("TMIRefOn at 1ms = %g V\n" v_tmon)
    printf("TMIRefMeas at 1.6ms = %g V\n" v_tmmeas)
    printf("GPIO8 at 1.6ms = %g V\n" v_gpio8)
    printf("============================\n")
)
exit()
