simulator( 'ams )
design( "BVU025_Lary" "sim_Bias_cosim_A1" "config" )
openResults("/home/lary/simulation/BVU025/BVU025A/sim_Bias_cosim_A1/ams/config/psf")
selectResult('tran)
outp = outfile("/tmp/current_sim_status.txt")
fprintf(outp "=== WAVEFORM PROBE AT 1.1ms ===\n")
fprintf(outp "v(xIRefTMIO) = %g\n" value(v("xIRefTMIO") 1.1m))
fprintf(outp "v(I_Bias/xIRefTMIOi) = %g\n" value(v("I_Bias/xIRefTMIOi") 1.1m))
fprintf(outp "v(I_Bias/IBP_Res) = %g\n" value(v("I_Bias/IBP_Res") 1.1m))
fprintf(outp "v(aTrimRef_5) = %g\n" value(v("aTrimRef_5") 1.1m))
fprintf(outp "v(aTrimRef_4) = %g\n" value(v("aTrimRef_4") 1.1m))
fprintf(outp "v(aTrimRef_3) = %g\n" value(v("aTrimRef_3") 1.1m))
fprintf(outp "v(aTrimRef_2) = %g\n" value(v("aTrimRef_2") 1.1m))
fprintf(outp "v(aTrimRef_1) = %g\n" value(v("aTrimRef_1") 1.1m))
fprintf(outp "v(aTrimRef_0) = %g\n" value(v("aTrimRef_0") 1.1m))
fprintf(outp "v(dIRefTMO) = %g\n" value(v("dIRefTMO") 1.1m))
close(outp)
exit()
