simulator( 'ams )
design( "BVU025_Lary" "sim_Bias_cosim_A1" "config" )
openResults("/home/lary/simulation/BVU025/BVU025A/sim_Bias_cosim_A1/ams/config/psf")
selectResult('tran)
outp = outfile("/tmp/check_mn8_result.txt")
fprintf(outp "I(MN8:d) at 1.8ms = %g A\n" value(i("sim_Bias_cosim_A1.I_Bias.MN8.d") 1.8m))
fprintf(outp "v(xIRefTMIO) at 1.8ms = %g V\n" value(v("sim_Bias_cosim_A1.xIRefTMIO") 1.8m))
close(outp)
exit()
