simulator( 'ams )
design( "BVU025_Lary" "sim_Bias_cosim_A1" "config" )
openResults("/home/lary/simulation/BVU025/BVU025A/sim_Bias_cosim_A1/ams/config/psf")
selectResult('tran)
printf("VSTR at 1.0ms = %g\n" value(v("I_Bias.VSTR") 1.0m))
printf("VBN at 1.0ms = %g\n" value(v("I_Bias.VBN") 1.0m))
printf("VBP at 1.0ms = %g\n" value(v("I_Bias.VBP") 1.0m))
printf("VBPC at 1.0ms = %g\n" value(v("I_Bias.VBPC") 1.0m))
printf("I(MN0:d) at 1.0ms = %g\n" value(i("I_Bias.MN0:d") 1.0m))
outp = outfile("/tmp/check_startup.txt")
fprintf(outp "VSTR=%g VBN=%g VBP=%g VBPC=%g IMN0=%g\n" value(v("I_Bias.VSTR") 1.0m) value(v("I_Bias.VBN") 1.0m) value(v("I_Bias.VBP") 1.0m) value(v("I_Bias.VBPC") 1.0m) value(i("I_Bias.MN0:d") 1.0m))
close(outp)
exit()
