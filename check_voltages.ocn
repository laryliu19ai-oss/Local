simulator( 'ams )
design( "BVU025_Lary" "sim_Bias_cosim_A1" "config" )
openResults("/home/lary/simulation/BVU025/BVU025A/sim_Bias_cosim_A1/ams/config/psf")
selectResult('tran)
p = outfile("/tmp/ocean_voltages.txt")
fprintf(p "=== FINAL VOLTAGES at t=1.0ms ===\n")
fprintf(p "aVdd = %g\n" value(v("/aVdd") 1.0m))
fprintf(p "IBP_Res = %g\n" value(v("/I_Bias/IBP_Res") 1.0m))
fprintf(p "VBP = %g\n" value(v("/I_Bias/VBP") 1.0m))
fprintf(p "VBN = %g\n" value(v("/I_Bias/VBN") 1.0m))
fprintf(p "VBNC = %g\n" value(v("/I_Bias/VBNC") 1.0m))
fprintf(p "dIRefTMO = %g\n" value(v("/dIRefTMO") 1.0m))
fprintf(p "aTrimRef_5 = %g\n" value(v("/aTrimRef_5") 1.0m))
fprintf(p "Code_5 = %g\n" value(v("/I_Bias/I0/Code_5") 1.0m))
fprintf(p "Code_i_5 = %g\n" value(v("/I_Bias/I0/Code_i_5") 1.0m))
fprintf(p "Code_0 = %g\n" value(v("/I_Bias/I0/Code_0") 1.0m))
fprintf(p "Code_i_0 = %g\n" value(v("/I_Bias/I0/Code_i_0") 1.0m))
close(p)
exit()
