simulator( 'ams )
design( "BVU025_Lary" "sim_Bias_cosim_A1" "config" )
openResults("/home/lary/simulation/BVU025/BVU025A/sim_Bias_cosim_A1/ams/config/psf")
selectResult('tran)
p = outfile("/tmp/ocean_voltages2.txt")
fprintf(p "xIRefTMIO = %g\n" value(v("/xIRefTMIO") 1.0m))
fprintf(p "TMIO_ESD = %g\n" value(v("/I_Bias/TMIO_ESD") 1.0m))
fprintf(p "xIRefTMIOi = %g\n" value(v("/I_Bias/xIRefTMIOi") 1.0m))
fprintf(p "TMIRefOn = %g\n" value(v("/TMIRefOn") 1.0m))
fprintf(p "TMIRefOnB = %g\n" value(v("/I_Bias/TMIRefOnB") 1.0m))
fprintf(p "TMIRefOnA = %g\n" value(v("/I_Bias/TMIRefOnA") 1.0m))
close(p)
exit()
